# Ansys Electronics Desktop project, version 2015.0
materials:
  vacuum: permittivity=1
  PVC plastic: permittivity=2.7 dielectric_loss_tangent=0.007
  water_distilled: permittivity=81 permeability=0.999991 conductivity=0.0002

design 3.5cm radius (12.5cm) (HFSS, DrivenModal, model units mm)
variables:
  a = 34.9nH
  b = 7.95pF
  c = 2pF
geometry:
  Sphere1 [PVC plastic] = sphere(centre=(0mm, 0mm, 0mm), radius=125mm)
  Sphere1.split(plane=XY, keep=PositiveOnly)
  Sphere2 = sphere(centre=(0mm, 0mm, 0mm), radius=122mm)
  Sphere2.split(plane=XY, keep=PositiveOnly)
  Sphere1.subtract(Sphere2)
  coordinate_system RelativeCS1 = origin=(-5mm, 114mm, 0mm) x=(1mm, 0mm, 0mm) y=(0mm, 1mm, 0mm)
  Sphere3 [water_distilled] = sphere(centre=(0mm, 0mm, 0mm), radius=118mm)
  Circle1 = circle(normal=Y, centre=(0mm, 125mm, 50mm), radius=35mm)
  Circle2 = circle(normal=Y, centre=(0mm, 125mm, 50mm), radius=30mm)
  Circle1.subtract(Circle2)
  Circle1.separate_bodies()
  Sphere1_1 = Sphere1.copy()
  Sphere1_1.delete()
  Circle1.wrap_sheet(SheetBody=834 TargetBody=851)
  Circle1_Split1 = Circle1.split(plane=YZ, keep=Both)
  Circle1_Split2 = Circle1.split(plane=YZ, keep=Both) in RelativeCS1
  coordinate_system RelativeCS2 = origin=(5mm, 10.62792mm, 9.6375082mm) x=(1mm, 0mm, 0mm) y=(0mm, 1mm, 0mm) in RelativeCS1
  Circle1_Split2.separate_bodies()
  Circle1.unite(Circle1_Split1, Circle1_Split2)
  Polyline1 = polyline(x=0mm, yz in mm: (124.62792, 9.6375082) (130, 9.8) (130, 5) (124.91363, 4.6460116) (124.62792, 9.6375082), closed, covered)
  Polyline2 = polyline(x=-5mm, yz in mm: (124.49448, 10.056031) (129.5, 10) (129.5, 5) (124.79964, 5.0049204) (124.49448, 10.056031), closed, covered)
  Polyline3 = polyline(xyz in mm: (0, 130, 9.8) (-5, 129.5, 10) (-5, 129.5, 5) (0, 130, 5) (0, 130, 9.8), closed, covered)
  Box1 [vacuum] = box(corner=(300mm, 300mm, 0mm), size=(-600mm, -600mm, 600mm))
  Box1.move(0mm, 0mm, -300mm)
  Polyline4 = polyline(xyz in mm: (0, 124.62792, 9.6375082) (-5, 124.49448, 10.056031) (-5, 124.79964, 5.0049204) (0, 124.91363, 4.6460116) (0, 124.62792, 9.6375082), closed, covered)
boundaries and excitations:
  Rad1: Radiation Objects=Box1
  LumpRLC1: Lumped RLC Objects=Circle1 CurrentLine{middle of Circle1.edge(at (0, 125, 20)) -> middle of Circle1.edge(1 of 1)} Inductance=23.5nH
  LumpRLC2: Lumped RLC Objects=Polyline4 CurrentLine{Polyline4.vertex(1 of 4) -> Polyline4.vertex(2 of 4)} Capacitance=4pF
  PerfE1: Perfect E Objects=Polyline1
  LumpRLC3: Lumped RLC Objects=Polyline2 CurrentLine{Polyline2.vertex(2 of 4) -> Polyline2.vertex(1 of 4)} Capacitance=5.5pF
  1: Lumped Port Objects=Polyline3 Modes{Mode1{IntLine{Polyline3.vertex(1 of 4) -> Polyline3.vertex(2 of 4)} CharImp=Zpi RenormImp=50ohm}} FullResistance=50ohm FullReactance=0ohm
mesh:
  initial mesh: GlobalSurfApproximation{SurfDevChoice=0 NormalDevChoice=1 AspectRatioChoice=1 SetFacePreservationLevel=0}
setups:
  Setup1: HfssDriven Frequency=63.8MHz MaxDeltaS=0.02 MaximumPasses=6 MinimumPasses=1 MinimumConvergedPasses=1 PercentRefinement=30 BasisOrder=1 PortAccuracy=2
    sweep Sweep: 10MHz to 70MHz step 1MHz; Type=Interpolating InterpTolerance=0.5 InterpMaxSolns=250 InterpUsePortImped=false PassivityErrorTolerance=0.0001
source amplitudes:
  1:1: 1W 0deg
reports:
  XY Plot 1: dB(S(1,1)) vs Freq on Setup1 : Sweep; markers m1 at 65MHz

design 3.5cm radius (8.5cm head) (HFSS, DrivenModal, model units mm)
variables:
  a = 20nH
  b = 7.72pF
geometry:
  Sphere1 [PVC plastic] = sphere(centre=(0mm, 0mm, 0mm), radius=85mm)
  Sphere2 = sphere(centre=(0mm, 0mm, 0mm), radius=82mm)
  Sphere1.subtract(Sphere2)
  Sphere1.split(plane=XY, keep=PositiveOnly)
  Circle1 = circle(normal=Y, centre=(0mm, 85mm, 60mm), radius=35mm)
  Circle2 = circle(normal=Y, centre=(0mm, 85mm, 60mm), radius=33mm)
  Circle1.subtract(Circle2)
  Circle1.separate_bodies()
  Sphere1_1 = Sphere1.copy()
  Sphere1_1.delete()
  Circle1.wrap_sheet(SheetBody=43 TargetBody=108)
  Circle1_Split1 = Circle1.split(plane=YZ, keep=Both)
  coordinate_system RelativeCS1 = origin=(0mm, 84.928927mm, 3.4752477mm) x=(1mm, 0mm, 0mm) y=(0mm, 1mm, 0mm)
  coordinate_system RelativeCS2 = origin=(-6.5mm, 0mm, 0.5mm) x=(1mm, 0mm, 0mm) y=(0mm, 1mm, 0mm) in RelativeCS1
  Circle1_Split2 = Circle1.split(plane=YZ, keep=Both) in RelativeCS2
  Circle1_Split2_Separate1 = Circle1_Split2.separate_bodies()
  Circle1.unite(Circle1_Split1, Circle1_Split2)
  Polyline1 = polyline(x=0mm, yz in mm: (84.928927, 3.4752477) (87.5, 3.5) (87.5, 1.5) (84.987181, 1.4761425) (84.928927, 3.4752477), closed, covered)
  Polyline2 = polyline(xyz in mm: (-6.5, 84.667571, 3.7619738) (-6.4, 87, 3.8) (-6.4, 87, 1.8) (-6.5, 84.733116, 1.7461311) (-6.5, 84.667571, 3.7619738), closed, covered)
  Polyline3 = polyline(xyz in mm: (0, 87.5, 3.5) (-6.4, 87, 3.8) (-6.4, 87, 1.8) (0, 87.5, 1.5) (0, 87.5, 3.5), closed, covered)
  Box1 [vacuum] = box(corner=(300mm, 300mm, 0mm), size=(-600mm, -600mm, 600mm))
  Box1.move(0mm, 0mm, -300mm)
  Polyline1.unite(Polyline2)
  Sphere3 [water_distilled] = sphere(centre=(0mm, 0mm, 0mm), radius=80mm)
boundaries and excitations:
  Rad1: Radiation Objects=Box1
  LumpRLC1: Lumped RLC Objects=Circle1 CurrentLine{middle of Circle1.edge(at (0, 85, 27)) -> middle of Circle1.edge(1 of 1)} Inductance=4nH
  LumpRLC2: Lumped RLC Objects=Circle1_Split2_Separate1 CurrentLine{Circle1.vertex(7 of 8) -> Circle1.vertex(6 of 8)} Capacitance=19pF
  PerfE1: Perfect E Objects=Polyline1
  1: Lumped Port Objects=Polyline3 Modes{Mode1{IntLine{Polyline3.vertex(1 of 4) -> Polyline3.vertex(2 of 4)} CharImp=Zpi RenormImp=50ohm}} FullResistance=50ohm FullReactance=0ohm
mesh:
  initial mesh: GlobalSurfApproximation{SurfDevChoice=0 NormalDevChoice=1 AspectRatioChoice=1 SetFacePreservationLevel=0}
setups:
  Setup1: HfssDriven Frequency=64MHz MaxDeltaS=0.02 MaximumPasses=6 MinimumPasses=1 MinimumConvergedPasses=1 PercentRefinement=30 BasisOrder=1 PortAccuracy=2
    sweep Sweep: 10MHz to 70MHz step 1MHz; Type=Interpolating InterpTolerance=0.5 InterpMaxSolns=250 InterpUsePortImped=false PassivityErrorTolerance=0.0001
source amplitudes:
  1:1: 1W 0deg
reports:
  XY Plot 1: dB(S(1,1)) vs Freq on Setup1 : Sweep; markers m1 at 63MHz

design 3.5cm radius (10cm head) (HFSS, DrivenModal, model units mm)
variables:
  a = 20nH
  b = 15pF
geometry:
  Sphere1 [PVC plastic] = sphere(centre=(0mm, 0mm, 0mm), radius=100mm)
  Sphere1.split(plane=XY, keep=PositiveOnly)
  Sphere2 = sphere(centre=(0mm, 0mm, 0mm), radius=97mm)
  Sphere2.split(plane=XY, keep=PositiveOnly)
  Sphere1.subtract(Sphere2)
  Circle1 = circle(normal=Y, centre=(0mm, 100mm, 50mm), radius=35mm)
  Circle2 = circle(normal=Y, centre=(0mm, 100mm, 50mm), radius=33mm)
  Circle1.subtract(Circle2)
  Circle1.separate_bodies()
  Sphere1_1 = Sphere1.copy()
  Sphere1_1.delete()
  Circle1.wrap_sheet(SheetBody=26 TargetBody=43)
  Sphere3 [water_distilled] = sphere(centre=(0mm, 0mm, 0mm), radius=95mm)
  Circle1_Split1 = Circle1.split(plane=YZ, keep=Both)
  coordinate_system RelativeCS1 = origin=(0mm, 99.970004mm, 2.4491613mm) x=(1mm, 0mm, 0mm) y=(0mm, 1mm, 0mm)
  coordinate_system RelativeCS2 = origin=(-3.4mm, -0.2mm, 0mm) x=(1mm, 0mm, 0mm) y=(0mm, 1mm, 0mm) in RelativeCS1
  Circle1_Split2 = Circle1.split(plane=YZ, keep=Both) in RelativeCS2
  Circle1_Split2_Separate1 = Circle1_Split2.separate_bodies()
  Circle1.unite(Circle1_Split1, Circle1_Split2)
  Polyline1 = polyline(x=0mm, yz in mm: (99.970004, 2.4491613) (102.5, 2.5) (102.5, 0.5) (99.99899, 0.44940444) (99.970004, 2.4491613), closed, covered)
  Polyline2 = polyline(x=-3.4mm, yz in mm: (99.90771, 2.6247914) (103.6, 2.6) (103.6, 0.8) (99.940291, 0.61500015) (99.90771, 2.6247914), closed, covered)
  Polyline3 = polyline(xyz in mm: (0, 102.5, 2.5) (-3.4, 103.6, 2.6) (-3.4, 103.6, 0.8) (0, 102.5, 0.5) (0, 102.5, 2.5), closed, covered)
  Box1 [vacuum] = box(corner=(300mm, 300mm, 0mm), size=(-600mm, -600mm, 600mm))
  Box1.move(0mm, 0mm, -300mm)
  Polyline1.unite(Polyline2)
boundaries and excitations:
  Rad1: Radiation Objects=Box1
  LumpRLC1: Lumped RLC Objects=Circle1 CurrentLine{middle of Circle1.edge(at (0, 100, 17)) -> middle of Circle1.edge(1 of 1)} Inductance=3.8nH
  LumpRLC2: Lumped RLC Objects=Circle1_Split2_Separate1 CurrentLine{Circle1.vertex(7 of 8) -> Circle1.vertex(6 of 8)} Capacitance=b
  PerfE1: Perfect E Objects=Polyline1
  1: Lumped Port Objects=Polyline3 Modes{Mode1{IntLine{Polyline3.vertex(1 of 4) -> Polyline3.vertex(2 of 4)} CharImp=Zpi RenormImp=50ohm}} FullResistance=50ohm FullReactance=0ohm
mesh:
  initial mesh: GlobalSurfApproximation{SurfDevChoice=0 NormalDevChoice=1 AspectRatioChoice=1 SetFacePreservationLevel=0}
setups:
  Setup1: HfssDriven Frequency=64MHz MaxDeltaS=0.02 MaximumPasses=6 MinimumPasses=1 MinimumConvergedPasses=1 PercentRefinement=30 BasisOrder=1 PortAccuracy=2
    sweep Sweep: 10MHz to 70MHz step 1MHz; Type=Interpolating InterpTolerance=0.5 InterpMaxSolns=250 InterpUsePortImped=false PassivityErrorTolerance=0.0001
source amplitudes:
  1:1: 1W 0deg
optimetrics:
  ParametricSetup1: Parametric Sim._Setups=[Setup1]
    sweep b: LIN 10pF 20pF 1pF

design initial x16 placement (HFSS, DrivenModal, model units mm)
geometry:
  Sphere1 [PVC plastic] = sphere(centre=(0mm, 0mm, 0mm), radius=85mm)
  Sphere2 = sphere(centre=(0mm, 0mm, 0mm), radius=82mm)
  Sphere1.subtract(Sphere2)
  Sphere1.split(plane=XY, keep=PositiveOnly)
  Sphere1_1 = Sphere1.copy()
  Circle1 = circle(normal=Y, centre=(0mm, 85mm, 60mm), radius=35mm)
  Circle2 = circle(normal=Y, centre=(0mm, 85mm, 60mm), radius=33mm)
  Circle1.subtract(Circle2)
  Circle1.separate_bodies()
  Circle1.wrap_sheet(SheetBody=43 TargetBody=108)
  Circle1_Split1 = Circle1.split(plane=YZ, keep=Both)
  coordinate_system RelativeCS1 = origin=(0mm, 84.928927mm, 3.4752477mm) x=(1mm, 0mm, 0mm) y=(0mm, 1mm, 0mm)
  coordinate_system RelativeCS2 = origin=(-6.5mm, 0mm, 0.5mm) x=(1mm, 0mm, 0mm) y=(0mm, 1mm, 0mm) in RelativeCS1
  Circle1_Split2 = Circle1.split(plane=YZ, keep=Both) in RelativeCS2
  Circle1_Split2_Separate1 = Circle1_Split2.separate_bodies()
  Circle1.unite(Circle1_Split1, Circle1_Split2)
  Polyline1 = polyline(x=0mm, yz in mm: (84.928927, 3.4752477) (87.5, 3.5) (87.5, 1.5) (84.987181, 1.4761425) (84.928927, 3.4752477), closed, covered)
  Polyline2 = polyline(xyz in mm: (-6.5, 84.667571, 3.7619738) (-6.4, 87, 3.8) (-6.4, 87, 1.8) (-6.5, 84.733116, 1.7461311) (-6.5, 84.667571, 3.7619738), closed, covered)
  Polyline1.unite(Polyline2)
  Polyline3 = polyline(xyz in mm: (0, 87.5, 3.5) (-6.4, 87, 3.8) (-6.4, 87, 1.8) (0, 87.5, 1.5) (0, 87.5, 3.5), closed, covered)
  Box1 [vacuum] = box(corner=(300mm, 300mm, 0mm), size=(-600mm, -600mm, 600mm))
  Box1.move(0mm, 0mm, -300mm)
  Sphere3 [water_distilled] = sphere(centre=(0mm, 0mm, 0mm), radius=80mm)
  Sphere1_1.delete()
  Polyline3_1..Polyline3_8 = Polyline3.duplicate_around_axis(axis=Z, angle=40deg, total=9)
  Circle1_1..Circle1_8 = Circle1.duplicate_around_axis(axis=Z, angle=40deg, total=9)
  Circle1_Split2_Separate1_1..Circle1_Split2_Separate1_8 = Circle1_Split2_Separate1.duplicate_around_axis(axis=Z, angle=40deg, total=9)
  Polyline1_1..Polyline1_8 = Polyline1.duplicate_around_axis(axis=Z, angle=40deg, total=9)
  Polyline3_9 = Polyline3.duplicate_around_axis(axis=X, angle=70deg, total=2)
  Circle1_9 = Circle1.duplicate_around_axis(axis=X, angle=70deg, total=2)
  Circle1_Split2_Separate1_9 = Circle1_Split2_Separate1.duplicate_around_axis(axis=X, angle=70deg, total=2)
  Polyline1_9 = Polyline1.duplicate_around_axis(axis=X, angle=70deg, total=2)
  Polyline3_9_1 = Polyline3_9.duplicate_around_axis(axis=X, angle=32deg, total=2)
  Circle1_9_1 = Circle1_9.duplicate_around_axis(axis=X, angle=32deg, total=2)
  Circle1_Split2_Separate1_9_1 = Circle1_Split2_Separate1_9.duplicate_around_axis(axis=X, angle=32deg, total=2)
  Polyline1_9_1 = Polyline1_9.duplicate_around_axis(axis=X, angle=32deg, total=2)
  Polyline3_9_1_1..Polyline3_9_1_5 = Polyline3_9_1.duplicate_around_axis(axis=Z, angle=60deg, total=6)
  Circle1_9_1_1..Circle1_9_1_5 = Circle1_9_1.duplicate_around_axis(axis=Z, angle=60deg, total=6)
  Circle1_Split2_Separate1_9_1_1..Circle1_Split2_Separate1_9_1_5 = Circle1_Split2_Separate1_9_1.duplicate_around_axis(axis=Z, angle=60deg, total=6)
  Polyline1_9_1_1..Polyline1_9_1_5 = Polyline1_9_1.duplicate_around_axis(axis=Z, angle=60deg, total=6)
boundaries and excitations:
  Rad1: Radiation Objects=Box1
  LumpRLC1: Lumped RLC Objects=Circle1 CurrentLine{middle of Circle1.edge(at (0, 85, 27)) -> middle of Circle1.edge(1 of 1)} Inductance=4nH
  LumpRLC2: Lumped RLC Objects=Circle1_Split2_Separate1 CurrentLine{Circle1.vertex(7 of 8) -> Circle1.vertex(6 of 8)} Capacitance=19pF
  PerfE1: Perfect E Objects=Polyline1
  LumpRLC3: Lumped RLC Objects=Circle1_1 CurrentLine{middle of Circle1_1.edge(7 of 8) -> middle of Circle1_1.edge(1 of 8)} Inductance=4nH
  LumpRLC4: Lumped RLC Objects=Circle1_Split2_Separate1_1 CurrentLine{Circle1_Split2_Separate1_1.vertex(3 of 4) -> Circle1_Split2_Separate1_1.vertex(2 of 4)} Capacitance=19pF
  PerfE2: Perfect E Objects=Polyline1_1
  LumpRLC5: Lumped RLC Objects=Circle1_2 CurrentLine{middle of Circle1_2.edge(7 of 8) -> middle of Circle1_2.edge(1 of 8)} Inductance=4nH
  LumpRLC6: Lumped RLC Objects=Circle1_Split2_Separate1_2 CurrentLine{Circle1_Split2_Separate1_2.vertex(3 of 4) -> Circle1_Split2_Separate1_2.vertex(2 of 4)} Capacitance=19pF
  PerfE3: Perfect E Objects=Polyline1_2
  LumpRLC7: Lumped RLC Objects=Circle1_3 CurrentLine{middle of Circle1_3.edge(7 of 8) -> middle of Circle1_3.edge(1 of 8)} Inductance=4nH
  LumpRLC8: Lumped RLC Objects=Circle1_Split2_Separate1_3 CurrentLine{Circle1_Split2_Separate1_3.vertex(3 of 4) -> Circle1_Split2_Separate1_3.vertex(2 of 4)} Capacitance=19pF
  PerfE4: Perfect E Objects=Polyline1_3
  LumpRLC9: Lumped RLC Objects=Circle1_4 CurrentLine{middle of Circle1_4.edge(7 of 8) -> middle of Circle1_4.edge(1 of 8)} Inductance=4nH
  LumpRLC10: Lumped RLC Objects=Circle1_Split2_Separate1_4 CurrentLine{Circle1_Split2_Separate1_4.vertex(3 of 4) -> Circle1_Split2_Separate1_4.vertex(2 of 4)} Capacitance=19pF
  PerfE5: Perfect E Objects=Polyline1_4
  LumpRLC11: Lumped RLC Objects=Circle1_5 CurrentLine{middle of Circle1_5.edge(7 of 8) -> middle of Circle1_5.edge(1 of 8)} Inductance=4nH
  LumpRLC12: Lumped RLC Objects=Circle1_Split2_Separate1_5 CurrentLine{Circle1_Split2_Separate1_5.vertex(3 of 4) -> Circle1_Split2_Separate1_5.vertex(2 of 4)} Capacitance=19pF
  PerfE6: Perfect E Objects=Polyline1_5
  LumpRLC13: Lumped RLC Objects=Circle1_6 CurrentLine{middle of Circle1_6.edge(7 of 8) -> middle of Circle1_6.edge(1 of 8)} Inductance=4nH
  LumpRLC14: Lumped RLC Objects=Circle1_Split2_Separate1_6 CurrentLine{Circle1_Split2_Separate1_6.vertex(3 of 4) -> Circle1_Split2_Separate1_6.vertex(2 of 4)} Capacitance=19pF
  PerfE7: Perfect E Objects=Polyline1_6
  LumpRLC15: Lumped RLC Objects=Circle1_7 CurrentLine{middle of Circle1_7.edge(7 of 8) -> middle of Circle1_7.edge(1 of 8)} Inductance=4nH
  LumpRLC16: Lumped RLC Objects=Circle1_Split2_Separate1_7 CurrentLine{Circle1_Split2_Separate1_7.vertex(3 of 4) -> Circle1_Split2_Separate1_7.vertex(2 of 4)} Capacitance=19pF
  PerfE8: Perfect E Objects=Polyline1_7
  LumpRLC17: Lumped RLC Objects=Circle1_8 CurrentLine{middle of Circle1_8.edge(7 of 8) -> middle of Circle1_8.edge(1 of 8)} Inductance=4nH
  LumpRLC18: Lumped RLC Objects=Circle1_Split2_Separate1_8 CurrentLine{Circle1_Split2_Separate1_8.vertex(3 of 4) -> Circle1_Split2_Separate1_8.vertex(2 of 4)} Capacitance=19pF
  PerfE9: Perfect E Objects=Polyline1_8
  LumpRLC19: Lumped RLC Objects=Circle1_9 CurrentLine{middle of Circle1_9.edge(7 of 8) -> middle of Circle1_9.edge(1 of 8)} Inductance=4nH
  LumpRLC20: Lumped RLC Objects=Circle1_Split2_Separate1_9 CurrentLine{Circle1_Split2_Separate1_9.vertex(3 of 4) -> Circle1_Split2_Separate1_9.vertex(2 of 4)} Capacitance=19pF
  PerfE10: Perfect E Objects=Polyline1_9
  LumpRLC21: Lumped RLC Objects=Circle1_9_1 CurrentLine{middle of Circle1_9_1.edge(7 of 8) -> middle of Circle1_9_1.edge(1 of 8)} Inductance=4nH
  LumpRLC22: Lumped RLC Objects=Circle1_Split2_Separate1_9_1 CurrentLine{Circle1_Split2_Separate1_9_1.vertex(3 of 4) -> Circle1_Split2_Separate1_9_1.vertex(2 of 4)} Capacitance=19pF
  PerfE11: Perfect E Objects=Polyline1_9_1
  LumpRLC23: Lumped RLC Objects=Circle1_9_1_1 CurrentLine{middle of Circle1_9_1_1.edge(7 of 8) -> middle of Circle1_9_1_1.edge(1 of 8)} Inductance=4nH
  LumpRLC24: Lumped RLC Objects=Circle1_Split2_Separate1_9_1_1 CurrentLine{Circle1_Split2_Separate1_9_1_1.vertex(3 of 4) -> Circle1_Split2_Separate1_9_1_1.vertex(2 of 4)} Capacitance=19pF
  PerfE12: Perfect E Objects=Polyline1_9_1_1
  LumpRLC25: Lumped RLC Objects=Circle1_9_1_2 CurrentLine{middle of Circle1_9_1_2.edge(7 of 8) -> middle of Circle1_9_1_2.edge(1 of 8)} Inductance=4nH
  LumpRLC26: Lumped RLC Objects=Circle1_Split2_Separate1_9_1_2 CurrentLine{Circle1_Split2_Separate1_9_1_2.vertex(3 of 4) -> Circle1_Split2_Separate1_9_1_2.vertex(2 of 4)} Capacitance=19pF
  PerfE13: Perfect E Objects=Polyline1_9_1_2
  LumpRLC27: Lumped RLC Objects=Circle1_9_1_3 CurrentLine{middle of Circle1_9_1_3.edge(7 of 8) -> middle of Circle1_9_1_3.edge(1 of 8)} Inductance=4nH
  LumpRLC28: Lumped RLC Objects=Circle1_Split2_Separate1_9_1_3 CurrentLine{Circle1_Split2_Separate1_9_1_3.vertex(3 of 4) -> Circle1_Split2_Separate1_9_1_3.vertex(2 of 4)} Capacitance=19pF
  PerfE14: Perfect E Objects=Polyline1_9_1_3
  LumpRLC29: Lumped RLC Objects=Circle1_9_1_4 CurrentLine{middle of Circle1_9_1_4.edge(7 of 8) -> middle of Circle1_9_1_4.edge(1 of 8)} Inductance=4nH
  LumpRLC30: Lumped RLC Objects=Circle1_Split2_Separate1_9_1_4 CurrentLine{Circle1_Split2_Separate1_9_1_4.vertex(3 of 4) -> Circle1_Split2_Separate1_9_1_4.vertex(2 of 4)} Capacitance=19pF
  PerfE15: Perfect E Objects=Polyline1_9_1_4
  LumpRLC31: Lumped RLC Objects=Circle1_9_1_5 CurrentLine{middle of Circle1_9_1_5.edge(7 of 8) -> middle of Circle1_9_1_5.edge(1 of 8)} Inductance=4nH
  LumpRLC32: Lumped RLC Objects=Circle1_Split2_Separate1_9_1_5 CurrentLine{Circle1_Split2_Separate1_9_1_5.vertex(3 of 4) -> Circle1_Split2_Separate1_9_1_5.vertex(2 of 4)} Capacitance=19pF
  PerfE16: Perfect E Objects=Polyline1_9_1_5
  1: Lumped Port Objects=Polyline3 Modes{Mode1{IntLine{Polyline3.vertex(1 of 4) -> Polyline3.vertex(2 of 4)} CharImp=Zpi RenormImp=50ohm}} FullResistance=50ohm FullReactance=0ohm
  2: Lumped Port Objects=Polyline3_1 Modes{Mode1{IntLine{Polyline3_1.vertex(1 of 4) -> Polyline3_1.vertex(2 of 4)} CharImp=Zpi RenormImp=50ohm}} FullResistance=50ohm FullReactance=0ohm
  3: Lumped Port Objects=Polyline3_2 Modes{Mode1{IntLine{Polyline3_2.vertex(1 of 4) -> Polyline3_2.vertex(2 of 4)} CharImp=Zpi RenormImp=50ohm}} FullResistance=50ohm FullReactance=0ohm
  4: Lumped Port Objects=Polyline3_3 Modes{Mode1{IntLine{Polyline3_3.vertex(1 of 4) -> Polyline3_3.vertex(2 of 4)} CharImp=Zpi RenormImp=50ohm}} FullResistance=50ohm FullReactance=0ohm
  5: Lumped Port Objects=Polyline3_4 Modes{Mode1{IntLine{Polyline3_4.vertex(1 of 4) -> Polyline3_4.vertex(2 of 4)} CharImp=Zpi RenormImp=50ohm}} FullResistance=50ohm FullReactance=0ohm
  6: Lumped Port Objects=Polyline3_5 Modes{Mode1{IntLine{Polyline3_5.vertex(1 of 4) -> Polyline3_5.vertex(2 of 4)} CharImp=Zpi RenormImp=50ohm}} FullResistance=50ohm FullReactance=0ohm
  7: Lumped Port Objects=Polyline3_6 Modes{Mode1{IntLine{Polyline3_6.vertex(1 of 4) -> Polyline3_6.vertex(2 of 4)} CharImp=Zpi RenormImp=50ohm}} FullResistance=50ohm FullReactance=0ohm
  8: Lumped Port Objects=Polyline3_7 Modes{Mode1{IntLine{Polyline3_7.vertex(1 of 4) -> Polyline3_7.vertex(2 of 4)} CharImp=Zpi RenormImp=50ohm}} FullResistance=50ohm FullReactance=0ohm
  9: Lumped Port Objects=Polyline3_8 Modes{Mode1{IntLine{Polyline3_8.vertex(1 of 4) -> Polyline3_8.vertex(2 of 4)} CharImp=Zpi RenormImp=50ohm}} FullResistance=50ohm FullReactance=0ohm
  10: Lumped Port Objects=Polyline3_9 Modes{Mode1{IntLine{Polyline3_9.vertex(1 of 4) -> Polyline3_9.vertex(2 of 4)} CharImp=Zpi RenormImp=50ohm}} FullResistance=50ohm FullReactance=0ohm
  11: Lumped Port Objects=Polyline3_9_1 Modes{Mode1{IntLine{Polyline3_9_1.vertex(1 of 4) -> Polyline3_9_1.vertex(2 of 4)} CharImp=Zpi RenormImp=50ohm}} FullResistance=50ohm FullReactance=0ohm
  12: Lumped Port Objects=Polyline3_9_1_1 Modes{Mode1{IntLine{Polyline3_9_1_1.vertex(1 of 4) -> Polyline3_9_1_1.vertex(2 of 4)} CharImp=Zpi RenormImp=50ohm}} FullResistance=50ohm FullReactance=0ohm
  13: Lumped Port Objects=Polyline3_9_1_2 Modes{Mode1{IntLine{Polyline3_9_1_2.vertex(1 of 4) -> Polyline3_9_1_2.vertex(2 of 4)} CharImp=Zpi RenormImp=50ohm}} FullResistance=50ohm FullReactance=0ohm
  14: Lumped Port Objects=Polyline3_9_1_3 Modes{Mode1{IntLine{Polyline3_9_1_3.vertex(1 of 4) -> Polyline3_9_1_3.vertex(2 of 4)} CharImp=Zpi RenormImp=50ohm}} FullResistance=50ohm FullReactance=0ohm
  15: Lumped Port Objects=Polyline3_9_1_4 Modes{Mode1{IntLine{Polyline3_9_1_4.vertex(1 of 4) -> Polyline3_9_1_4.vertex(2 of 4)} CharImp=Zpi RenormImp=50ohm}} FullResistance=50ohm FullReactance=0ohm
  16: Lumped Port Objects=Polyline3_9_1_5 Modes{Mode1{IntLine{Polyline3_9_1_5.vertex(1 of 4) -> Polyline3_9_1_5.vertex(2 of 4)} CharImp=Zpi RenormImp=50ohm}} FullResistance=50ohm FullReactance=0ohm
mesh:
  initial mesh: GlobalSurfApproximation{SurfDevChoice=0 NormalDevChoice=1 AspectRatioChoice=1 SetFacePreservationLevel=0}
setups:
  Setup1: HfssDriven Frequency=63.8MHz MaxDeltaS=0.02 MaximumPasses=6 MinimumPasses=1 MinimumConvergedPasses=1 PercentRefinement=30 BasisOrder=1 PortAccuracy=2
    sweep Sweep: 10MHz to 70MHz step 1MHz; Type=Interpolating InterpTolerance=0.5 InterpMaxSolns=250 InterpUsePortImped=false PassivityErrorTolerance=0.0001
source amplitudes:
  1:1: 1W 0deg
  2:1, 3:1, 4:1, 5:1, 6:1, 7:1, 8:1, 9:1, 10:1, 11:1, 12:1, 13:1, 14:1, 15:1, 16:1: 0W 0deg
reports:
  XY Plot 1: dB(S(1,2)) vs Freq on Setup1 : Sweep; markers m1 at 68MHz, m2 at 42MHz

design opti1 (HFSS, DrivenModal, model units mm)
geometry:
  Sphere1 [PVC plastic] = sphere(centre=(0mm, 0mm, 0mm), radius=85mm)
  Sphere2 = sphere(centre=(0mm, 0mm, 0mm), radius=82mm)
  Sphere1.subtract(Sphere2)
  Sphere1.split(plane=XY, keep=PositiveOnly)
  Sphere1_1 = Sphere1.copy()
  Circle1 = circle(normal=Y, centre=(0mm, 85mm, 60mm), radius=35mm)
  Circle2 = circle(normal=Y, centre=(0mm, 85mm, 60mm), radius=33mm)
  Circle1.subtract(Circle2)
  Circle1.separate_bodies()
  Circle1.wrap_sheet(SheetBody=43 TargetBody=108)
  Circle1_Split1 = Circle1.split(plane=YZ, keep=Both)
  coordinate_system RelativeCS1 = origin=(0mm, 84.928927mm, 3.4752477mm) x=(1mm, 0mm, 0mm) y=(0mm, 1mm, 0mm)
  coordinate_system RelativeCS2 = origin=(-6.5mm, 0mm, 0.5mm) x=(1mm, 0mm, 0mm) y=(0mm, 1mm, 0mm) in RelativeCS1
  Circle1_Split2 = Circle1.split(plane=YZ, keep=Both) in RelativeCS2
  Circle1_Split2_Separate1 = Circle1_Split2.separate_bodies()
  Circle1.unite(Circle1_Split1, Circle1_Split2)
  Polyline1 = polyline(x=0mm, yz in mm: (84.928927, 3.4752477) (87.5, 3.5) (87.5, 1.5) (84.987181, 1.4761425) (84.928927, 3.4752477), closed, covered)
  Polyline2 = polyline(xyz in mm: (-6.5, 84.667571, 3.7619738) (-6.4, 87, 3.8) (-6.4, 87, 1.8) (-6.5, 84.733116, 1.7461311) (-6.5, 84.667571, 3.7619738), closed, covered)
  Polyline1.unite(Polyline2)
  Polyline3 = polyline(xyz in mm: (0, 87.5, 3.5) (-6.4, 87, 3.8) (-6.4, 87, 1.8) (0, 87.5, 1.5) (0, 87.5, 3.5), closed, covered)
  Box1 [vacuum] = box(corner=(300mm, 300mm, 0mm), size=(-600mm, -600mm, 600mm))
  Box1.move(0mm, 0mm, -300mm)
  Sphere3 [water_distilled] = sphere(centre=(0mm, 0mm, 0mm), radius=80mm)
  Sphere1_1.delete()
  Polyline3_1..Polyline3_7 = Polyline3.duplicate_around_axis(axis=Z, angle=45deg, total=8)
  Circle1_1..Circle1_7 = Circle1.duplicate_around_axis(axis=Z, angle=45deg, total=8)
  Circle1_Split2_Separate1_1..Circle1_Split2_Separate1_7 = Circle1_Split2_Separate1.duplicate_around_axis(axis=Z, angle=45deg, total=8)
  Polyline1_1..Polyline1_7 = Polyline1.duplicate_around_axis(axis=Z, angle=45deg, total=8)
  Polyline3_8 = Polyline3.duplicate_around_axis(axis=X, angle=65deg, total=2)
  Circle1_8 = Circle1.duplicate_around_axis(axis=X, angle=65deg, total=2)
  Circle1_Split2_Separate1_8 = Circle1_Split2_Separate1.duplicate_around_axis(axis=X, angle=65deg, total=2)
  Polyline1_8 = Polyline1.duplicate_around_axis(axis=X, angle=65deg, total=2)
  Polyline3_8_1 = Polyline3_8.duplicate_around_axis(axis=X, angle=-25deg, total=2)
  Circle1_8_1 = Circle1_8.duplicate_around_axis(axis=X, angle=-25deg, total=2)
  Circle1_Split2_Separate1_8_1 = Circle1_Split2_Separate1_8.duplicate_around_axis(axis=X, angle=-25deg, total=2)
  Polyline1_8_1 = Polyline1_8.duplicate_around_axis(axis=X, angle=-25deg, total=2)
  Polyline3_8_1_1..Polyline3_8_1_6 = Polyline3_8_1.duplicate_around_axis(axis=Z, angle=50deg, total=7)
  Circle1_8_1_1..Circle1_8_1_6 = Circle1_8_1.duplicate_around_axis(axis=Z, angle=50deg, total=7)
  Circle1_Split2_Separate1_8_1_1..Circle1_Split2_Separate1_8_1_6 = Circle1_Split2_Separate1_8_1.duplicate_around_axis(axis=Z, angle=50deg, total=7)
  Polyline1_8_1_1..Polyline1_8_1_6 = Polyline1_8_1.duplicate_around_axis(axis=Z, angle=50deg, total=7)
boundaries and excitations:
  Rad1: Radiation Objects=Box1
  LumpRLC1: Lumped RLC Objects=Circle1 CurrentLine{middle of Circle1.edge(at (0, 85, 27)) -> middle of Circle1.edge(1 of 1)} Inductance=4nH
  LumpRLC2: Lumped RLC Objects=Circle1_Split2_Separate1 CurrentLine{Circle1.vertex(7 of 8) -> Circle1.vertex(6 of 8)} Capacitance=19pF
  PerfE1: Perfect E Objects=Polyline1
  LumpRLC3: Lumped RLC Objects=Circle1_1 CurrentLine{middle of Circle1_1.edge(7 of 8) -> middle of Circle1_1.edge(1 of 8)} Inductance=4nH
  LumpRLC4: Lumped RLC Objects=Circle1_Split2_Separate1_1 CurrentLine{Circle1_Split2_Separate1_1.vertex(3 of 4) -> Circle1_Split2_Separate1_1.vertex(2 of 4)} Capacitance=19pF
  PerfE2: Perfect E Objects=Polyline1_1
  LumpRLC5: Lumped RLC Objects=Circle1_2 CurrentLine{middle of Circle1_2.edge(7 of 8) -> middle of Circle1_2.edge(1 of 8)} Inductance=4nH
  LumpRLC6: Lumped RLC Objects=Circle1_Split2_Separate1_2 CurrentLine{Circle1_Split2_Separate1_2.vertex(3 of 4) -> Circle1_Split2_Separate1_2.vertex(2 of 4)} Capacitance=19pF
  PerfE3: Perfect E Objects=Polyline1_2
  LumpRLC7: Lumped RLC Objects=Circle1_3 CurrentLine{middle of Circle1_3.edge(7 of 8) -> middle of Circle1_3.edge(1 of 8)} Inductance=4nH
  LumpRLC8: Lumped RLC Objects=Circle1_Split2_Separate1_3 CurrentLine{Circle1_Split2_Separate1_3.vertex(3 of 4) -> Circle1_Split2_Separate1_3.vertex(2 of 4)} Capacitance=19pF
  PerfE4: Perfect E Objects=Polyline1_3
  LumpRLC9: Lumped RLC Objects=Circle1_4 CurrentLine{middle of Circle1_4.edge(7 of 8) -> middle of Circle1_4.edge(1 of 8)} Inductance=4nH
  LumpRLC10: Lumped RLC Objects=Circle1_Split2_Separate1_4 CurrentLine{Circle1_Split2_Separate1_4.vertex(3 of 4) -> Circle1_Split2_Separate1_4.vertex(2 of 4)} Capacitance=19pF
  PerfE5: Perfect E Objects=Polyline1_4
  LumpRLC11: Lumped RLC Objects=Circle1_5 CurrentLine{middle of Circle1_5.edge(7 of 8) -> middle of Circle1_5.edge(1 of 8)} Inductance=4nH
  LumpRLC12: Lumped RLC Objects=Circle1_Split2_Separate1_5 CurrentLine{Circle1_Split2_Separate1_5.vertex(3 of 4) -> Circle1_Split2_Separate1_5.vertex(2 of 4)} Capacitance=19pF
  PerfE6: Perfect E Objects=Polyline1_5
  LumpRLC13: Lumped RLC Objects=Circle1_6 CurrentLine{middle of Circle1_6.edge(7 of 8) -> middle of Circle1_6.edge(1 of 8)} Inductance=4nH
  LumpRLC14: Lumped RLC Objects=Circle1_Split2_Separate1_6 CurrentLine{Circle1_Split2_Separate1_6.vertex(3 of 4) -> Circle1_Split2_Separate1_6.vertex(2 of 4)} Capacitance=19pF
  PerfE7: Perfect E Objects=Polyline1_6
  LumpRLC15: Lumped RLC Objects=Circle1_7 CurrentLine{middle of Circle1_7.edge(7 of 8) -> middle of Circle1_7.edge(1 of 8)} Inductance=4nH
  LumpRLC16: Lumped RLC Objects=Circle1_Split2_Separate1_7 CurrentLine{Circle1_Split2_Separate1_7.vertex(3 of 4) -> Circle1_Split2_Separate1_7.vertex(2 of 4)} Capacitance=19pF
  PerfE8: Perfect E Objects=Polyline1_7
  LumpRLC17: Lumped RLC Objects=Circle1_8 CurrentLine{middle of Circle1_8.edge(7 of 8) -> middle of Circle1_8.edge(1 of 8)} Inductance=4nH
  LumpRLC18: Lumped RLC Objects=Circle1_Split2_Separate1_8 CurrentLine{Circle1_Split2_Separate1_8.vertex(3 of 4) -> Circle1_Split2_Separate1_8.vertex(2 of 4)} Capacitance=19pF
  PerfE9: Perfect E Objects=Polyline1_8
  LumpRLC19: Lumped RLC Objects=Circle1_8_1 CurrentLine{middle of Circle1_8_1.edge(7 of 8) -> middle of Circle1_8_1.edge(1 of 8)} Inductance=4nH
  LumpRLC20: Lumped RLC Objects=Circle1_Split2_Separate1_8_1 CurrentLine{Circle1_Split2_Separate1_8_1.vertex(3 of 4) -> Circle1_Split2_Separate1_8_1.vertex(2 of 4)} Capacitance=19pF
  PerfE10: Perfect E Objects=Polyline1_8_1
  LumpRLC21: Lumped RLC Objects=Circle1_8_1_1 CurrentLine{middle of Circle1_8_1_1.edge(7 of 8) -> middle of Circle1_8_1_1.edge(1 of 8)} Inductance=4nH
  LumpRLC22: Lumped RLC Objects=Circle1_Split2_Separate1_8_1_1 CurrentLine{Circle1_Split2_Separate1_8_1_1.vertex(3 of 4) -> Circle1_Split2_Separate1_8_1_1.vertex(2 of 4)} Capacitance=19pF
  PerfE11: Perfect E Objects=Polyline1_8_1_1
  LumpRLC23: Lumped RLC Objects=Circle1_8_1_2 CurrentLine{middle of Circle1_8_1_2.edge(7 of 8) -> middle of Circle1_8_1_2.edge(1 of 8)} Inductance=4nH
  LumpRLC24: Lumped RLC Objects=Circle1_Split2_Separate1_8_1_2 CurrentLine{Circle1_Split2_Separate1_8_1_2.vertex(3 of 4) -> Circle1_Split2_Separate1_8_1_2.vertex(2 of 4)} Capacitance=19pF
  PerfE12: Perfect E Objects=Polyline1_8_1_2
  LumpRLC25: Lumped RLC Objects=Circle1_8_1_3 CurrentLine{middle of Circle1_8_1_3.edge(7 of 8) -> middle of Circle1_8_1_3.edge(1 of 8)} Inductance=4nH
  LumpRLC26: Lumped RLC Objects=Circle1_Split2_Separate1_8_1_3 CurrentLine{Circle1_Split2_Separate1_8_1_3.vertex(3 of 4) -> Circle1_Split2_Separate1_8_1_3.vertex(2 of 4)} Capacitance=19pF
  PerfE13: Perfect E Objects=Polyline1_8_1_3
  LumpRLC27: Lumped RLC Objects=Circle1_8_1_4 CurrentLine{middle of Circle1_8_1_4.edge(7 of 8) -> middle of Circle1_8_1_4.edge(1 of 8)} Inductance=4nH
  LumpRLC28: Lumped RLC Objects=Circle1_Split2_Separate1_8_1_4 CurrentLine{Circle1_Split2_Separate1_8_1_4.vertex(3 of 4) -> Circle1_Split2_Separate1_8_1_4.vertex(2 of 4)} Capacitance=19pF
  PerfE14: Perfect E Objects=Polyline1_8_1_4
  LumpRLC29: Lumped RLC Objects=Circle1_8_1_5 CurrentLine{middle of Circle1_8_1_5.edge(7 of 8) -> middle of Circle1_8_1_5.edge(1 of 8)} Inductance=4nH
  LumpRLC30: Lumped RLC Objects=Circle1_Split2_Separate1_8_1_5 CurrentLine{Circle1_Split2_Separate1_8_1_5.vertex(3 of 4) -> Circle1_Split2_Separate1_8_1_5.vertex(2 of 4)} Capacitance=19pF
  PerfE15: Perfect E Objects=Polyline1_8_1_5
  LumpRLC31: Lumped RLC Objects=Circle1_8_1_6 CurrentLine{middle of Circle1_8_1_6.edge(7 of 8) -> middle of Circle1_8_1_6.edge(1 of 8)} Inductance=4nH
  LumpRLC32: Lumped RLC Objects=Circle1_Split2_Separate1_8_1_6 CurrentLine{Circle1_Split2_Separate1_8_1_6.vertex(3 of 4) -> Circle1_Split2_Separate1_8_1_6.vertex(2 of 4)} Capacitance=19pF
  PerfE16: Perfect E Objects=Polyline1_8_1_6
  1: Lumped Port Objects=Polyline3 Modes{Mode1{IntLine{Polyline3.vertex(1 of 4) -> Polyline3.vertex(2 of 4)} CharImp=Zpi RenormImp=50ohm}} FullResistance=50ohm FullReactance=0ohm
  2: Lumped Port Objects=Polyline3_1 Modes{Mode1{IntLine{Polyline3_1.vertex(1 of 4) -> Polyline3_1.vertex(2 of 4)} CharImp=Zpi RenormImp=50ohm}} FullResistance=50ohm FullReactance=0ohm
  3: Lumped Port Objects=Polyline3_2 Modes{Mode1{IntLine{Polyline3_2.vertex(1 of 4) -> Polyline3_2.vertex(2 of 4)} CharImp=Zpi RenormImp=50ohm}} FullResistance=50ohm FullReactance=0ohm
  4: Lumped Port Objects=Polyline3_3 Modes{Mode1{IntLine{Polyline3_3.vertex(1 of 4) -> Polyline3_3.vertex(2 of 4)} CharImp=Zpi RenormImp=50ohm}} FullResistance=50ohm FullReactance=0ohm
  5: Lumped Port Objects=Polyline3_4 Modes{Mode1{IntLine{Polyline3_4.vertex(1 of 4) -> Polyline3_4.vertex(2 of 4)} CharImp=Zpi RenormImp=50ohm}} FullResistance=50ohm FullReactance=0ohm
  6: Lumped Port Objects=Polyline3_5 Modes{Mode1{IntLine{Polyline3_5.vertex(1 of 4) -> Polyline3_5.vertex(2 of 4)} CharImp=Zpi RenormImp=50ohm}} FullResistance=50ohm FullReactance=0ohm
  7: Lumped Port Objects=Polyline3_6 Modes{Mode1{IntLine{Polyline3_6.vertex(1 of 4) -> Polyline3_6.vertex(2 of 4)} CharImp=Zpi RenormImp=50ohm}} FullResistance=50ohm FullReactance=0ohm
  8: Lumped Port Objects=Polyline3_7 Modes{Mode1{IntLine{Polyline3_7.vertex(1 of 4) -> Polyline3_7.vertex(2 of 4)} CharImp=Zpi RenormImp=50ohm}} FullResistance=50ohm FullReactance=0ohm
  9: Lumped Port Objects=Polyline3_8 Modes{Mode1{IntLine{Polyline3_8.vertex(1 of 4) -> Polyline3_8.vertex(2 of 4)} CharImp=Zpi RenormImp=50ohm}} FullResistance=50ohm FullReactance=0ohm
  10: Lumped Port Objects=Polyline3_8_1 Modes{Mode1{IntLine{Polyline3_8_1.vertex(1 of 4) -> Polyline3_8_1.vertex(2 of 4)} CharImp=Zpi RenormImp=50ohm}} FullResistance=50ohm FullReactance=0ohm
  11: Lumped Port Objects=Polyline3_8_1_1 Modes{Mode1{IntLine{Polyline3_8_1_1.vertex(1 of 4) -> Polyline3_8_1_1.vertex(2 of 4)} CharImp=Zpi RenormImp=50ohm}} FullResistance=50ohm FullReactance=0ohm
  12: Lumped Port Objects=Polyline3_8_1_2 Modes{Mode1{IntLine{Polyline3_8_1_2.vertex(1 of 4) -> Polyline3_8_1_2.vertex(2 of 4)} CharImp=Zpi RenormImp=50ohm}} FullResistance=50ohm FullReactance=0ohm
  13: Lumped Port Objects=Polyline3_8_1_3 Modes{Mode1{IntLine{Polyline3_8_1_3.vertex(1 of 4) -> Polyline3_8_1_3.vertex(2 of 4)} CharImp=Zpi RenormImp=50ohm}} FullResistance=50ohm FullReactance=0ohm
  14: Lumped Port Objects=Polyline3_8_1_4 Modes{Mode1{IntLine{Polyline3_8_1_4.vertex(1 of 4) -> Polyline3_8_1_4.vertex(2 of 4)} CharImp=Zpi RenormImp=50ohm}} FullResistance=50ohm FullReactance=0ohm
  15: Lumped Port Objects=Polyline3_8_1_5 Modes{Mode1{IntLine{Polyline3_8_1_5.vertex(1 of 4) -> Polyline3_8_1_5.vertex(2 of 4)} CharImp=Zpi RenormImp=50ohm}} FullResistance=50ohm FullReactance=0ohm
  16: Lumped Port Objects=Polyline3_8_1_6 Modes{Mode1{IntLine{Polyline3_8_1_6.vertex(1 of 4) -> Polyline3_8_1_6.vertex(2 of 4)} CharImp=Zpi RenormImp=50ohm}} FullResistance=50ohm FullReactance=0ohm
mesh:
  initial mesh: GlobalSurfApproximation{SurfDevChoice=0 NormalDevChoice=1 AspectRatioChoice=1 SetFacePreservationLevel=0}
setups:
  Setup1: HfssDriven Frequency=63.8MHz MaxDeltaS=0.02 MaximumPasses=6 MinimumPasses=1 MinimumConvergedPasses=1 PercentRefinement=30 BasisOrder=1 PortAccuracy=2
    sweep Sweep: 10MHz to 70MHz step 10MHz; Type=Interpolating InterpTolerance=0.5 InterpMaxSolns=250 InterpUsePortImped=false PassivityErrorTolerance=0.0001
source amplitudes:
  1:1: 1W 0deg
  2:1, 3:1, 4:1, 5:1, 6:1, 7:1, 8:1, 9:1, 10:1, 11:1, 12:1, 13:1, 14:1, 15:1, 16:1: 0W 0deg
